| / 7\'7
| \ \   Xilinx Inc.
| / /
| \_\/.\   IBIS Models for VIRTEX-6
[IBIS ver]   3.2
[File name]   MAIN.ibs
[File Rev]   1.8
|   1.6 - Updated [Package] header section.  See [Package] notes.
|   1.7 - Changed TDCI in signal names to T_DCI.
|   1.8 - Updated [Package] header section,
|   Updated driver characteristics
[Date]   Sun December 04 14:59:14 2016
[Source]   Derived from spice models, mbx40 r0.22, dated 04/30/2009 using
   hspice 2008.03
[Notes]   Xilinx IBIS file for VIRTEX-6 I/O standards.
   All models are preliminary.
   The version of IBISCHK used is ibischk4.
   Ibis models were generated using S2IBIS3.
   C_comp: The C_comp values for the models contained herein have been
   determined, using the procedure suggested in the IBIS Cookbook.
   That is, a 100 mV, 100 MHz sine wave is applied to the pad,
   and the imaginary part of the resulting current is used to
   determine the capacitance "seen" at that node.
   Two groups of typ./min./max. values are provided:
   Input Mode - These values are taken with the driver
   tristated, and are used as the defaults.
   Output Mode - These values are taken with the driver
   enabled, and are included as comments.
   Note) In order to use the Output Mode values, the user must
   comment out the Input Mode values, and uncomment the Output
   Mode values, for the particular standard of interest.
[Disclaimer] The data in this file is derived from SPICE simulations using
                 modeling information extracted from the target process. While
                 a great deal of care has been taken to provide information
                 that is accurate, this model is considered preliminary as it
                 has not been verified by actual silicon measurement. Treat the
                 data in this model as preliminary until actual silicon
                 verification is performed.
[Copyright]   Copyright 2009, Xilinx Inc., All rights reserved
|   Component VIRTEX-6
[Component]   VIRTEX-6
[Manufacturer]   Xilinx Inc.
[Package]
|FF484
|variable   typ   min   max
R_pkg   435.0m   36.0m   1056.0m
L_pkg   3.46nH   0.90nH   6.33nH
C_pkg   1.79pF   0.77pF   3.06pF
[Pin]  signal_name   model_name   R_pin   L_pin   C_pin
W18   RD1out<1>   LVCMOS25_S_12
W10   PC<0>   LVCMOS25_S_12
Y7   RD1out<2>   LVCMOS25_S_12
Y14   PC<1>   LVCMOS25_S_12
A9   eAC   LVCMOS25_S_12
T17   MA<10>   LVCMOS25_S_12
AA17   RD1out<3>   LVCMOS25_S_12
AB9   PC<2>   LVCMOS25_S_12
U18   MA<11>   LVCMOS25_S_12
AA6   RD1out<4>   LVCMOS25_S_12
W14   PC<3>   LVCMOS25_S_12
M21   ALU<10>   LVCMOS25_S_12
Y16   RD1out<5>   LVCMOS25_S_12
AB8   PC<4>   LVCMOS25_S_12
K19   IR<0>   LVCMOS25_S_12
AA19   ALU<11>   LVCMOS25_S_12
AA8   RD1out<6>   LVCMOS25_S_12
AA12   PC<5>   LVCMOS25_S_12
J19   IR<1>   LVCMOS25_S_12
AB18   ALU<12>   LVCMOS25_S_12
R15   RD1out<7>   LVCMOS25_S_12
U11   PC<6>   LVCMOS25_S_12
D20   IR<2>   LVCMOS25_S_12
U8   mux3out<10>   LVCMOS25_S_12
AB19   ALU<13>   LVCMOS25_S_12
U9   RD1out<8>   LVCMOS25_S_12
V11   PC<7>   LVCMOS25_S_12
E20   IR<3>   LVCMOS25_S_12
Y9   mux3out<11>   LVCMOS25_S_12
U21   mux1out<0>   LVCMOS25_S_12
Y19   ALU<14>   LVCMOS25_S_12
AA13   RD1out<9>   LVCMOS25_S_12
AA11   PC<8>   LVCMOS25_S_12
C22   IR<4>   LVCMOS25_S_12
T21   mux1out<1>   LVCMOS25_S_12
V15   ALU<15>   LVCMOS25_S_12
Y11   PC<9>   LVCMOS25_S_12
D22   IR<5>   LVCMOS25_S_12
P19   mux1out<2>   LVCMOS25_S_12
E21   IR<6>   LVCMOS25_S_12
P20   mux1out<3>   LVCMOS25_S_12
E22   IR<7>   LVCMOS25_S_12
W22   mux1out<4>   LVCMOS25_S_12
F21   IR<8>   LVCMOS25_S_12
D10   eMA   LVCMOS25_S_12
V22   mux1out<5>   LVCMOS25_S_12
W8   RD1out<10>   LVCMOS25_S_12
F22   IR<9>   LVCMOS25_S_12
R19   mux1out<6>   LVCMOS25_S_12
AB14   eMD   LVCMOS25_S_12
Y15   RD1out<11>   LVCMOS25_S_12
R20   mux1out<7>   LVCMOS25_S_12
U10   RD1out<12>   LVCMOS25_S_12
AB11   PC<10>   LVCMOS25_S_12
P18   mux1out<8>   LVCMOS25_S_12
U14   RD1out<13>   LVCMOS25_S_12
AB10   PC<11>   LVCMOS25_S_12
A12   ePC   LVCMOS25_S_12
R17   mux1out<9>   LVCMOS25_S_12
A11   eIR   LVCMOS25_S_12
Y10   RD1out<14>   LVCMOS25_S_12
B11   m1c   LVCMOS25_S_12
Y12   RD1out<15>   LVCMOS25_S_12
AA14   m2c   LVCMOS25_S_12
L18   MA<0>   LVCMOS25_S_12
AB15   eRD   LVCMOS25_S_12
AB16   m3c   LVCMOS25_S_12
L19   MA<1>   LVCMOS25_S_12
N18   ALU<0>   LVCMOS25_S_12
B10   ALUcont<0>   LVCMOS25_S_12
H20   MA<2>   LVCMOS25_S_12
M20   ALU<1>   LVCMOS25_S_12
C10   ALUcont<1>   LVCMOS25_S_12
V12   mux3out<0>   LVCMOS25_S_12
G20   MA<3>   LVCMOS25_S_12
T22   ALU<2>   LVCMOS25_S_12
C11   ALUcont<2>   LVCMOS25_S_12
W12   mux3out<1>   LVCMOS25_S_12
J22   MA<4>   LVCMOS25_S_12
N21   ALU<3>   LVCMOS25_S_12
T6   mux3out<2>   LVCMOS25_S_12
J20   IR<10>   LVCMOS25_S_12
H22   MA<5>   LVCMOS25_S_12
V13   ALU<4>   LVCMOS25_S_12
B9   eWD   LVCMOS25_S_12
T7   mux3out<3>   LVCMOS25_S_12
K20   IR<11>   LVCMOS25_S_12
K21   MA<6>   LVCMOS25_S_12
T16   ALU<5>   LVCMOS25_S_12
R9   mux3out<4>   LVCMOS25_S_12
H17   IR<12>   LVCMOS25_S_12
K22   MA<7>   LVCMOS25_S_12
V10   MD<10>   LVCMOS25_S_12
P17   ALU<6>   LVCMOS25_S_12
T8   mux3out<5>   LVCMOS25_S_12
H18   IR<13>   LVCMOS25_S_12
B22   RD2out<10>   LVCMOS25_S_12
T13   MA<8>   LVCMOS25_S_12
W15   MD<11>   LVCMOS25_S_12
P22   ALU<7>   LVCMOS25_S_12
U6   mux3out<6>   LVCMOS25_S_12
G21   IR<14>   LVCMOS25_S_12
C21   RD2out<11>   LVCMOS25_S_12
U13   MA<9>   LVCMOS25_S_12
N20   AC<10>   LVCMOS25_S_12
W9   MD<12>   LVCMOS25_S_12
V8   ALU<8>   LVCMOS25_S_12
V6   mux3out<7>   LVCMOS25_S_12
H21   IR<15>   LVCMOS25_S_12
K17   RD2out<12>   LVCMOS25_S_12
L22   AC<11>   LVCMOS25_S_12
T14   MD<13>   LVCMOS25_S_12
AA18   ALU<9>   LVCMOS25_S_12
T12   mux3out<8>   LVCMOS25_S_12
L17   RD2out<13>   LVCMOS25_S_12
V18   AC<12>   LVCMOS25_S_12
T9   MD<14>   LVCMOS25_S_12
T11   mux3out<9>   LVCMOS25_S_12
U19   mux1out<10>   LVCMOS25_S_12
E19   RD2out<14>   LVCMOS25_S_12
V17   AC<13>   LVCMOS25_S_12
W17   MD<0>   LVCMOS25_S_12
AB13   MD<15>   LVCMOS25_S_12
B20   RD2out<0>   LVCMOS25_S_12
U20   mux1out<11>   LVCMOS25_S_12
D19   RD2out<15>   LVCMOS25_S_12
M18   AC<0>   LVCMOS25_S_12
W19   AC<14>   LVCMOS25_S_12
V7   MD<1>   LVCMOS25_S_12
C20   RD2out<1>   LVCMOS25_S_12
M19   AC<1>   LVCMOS25_S_12
U16   AC<15>   LVCMOS25_S_12
Y6   MD<2>   LVCMOS25_S_12
G18   RD2out<2>   LVCMOS25_S_12
R21   AC<2>   LVCMOS25_S_12
Y17   MD<3>   LVCMOS25_S_12
F18   RD2out<3>   LVCMOS25_S_12
N22   AC<3>   LVCMOS25_S_12
AB6   MD<4>   LVCMOS25_S_12
A21   RD2out<4>   LVCMOS25_S_12
W13   AC<4>   LVCMOS25_S_12
AA16   MD<5>   LVCMOS25_S_12
B21   RD2out<5>   LVCMOS25_S_12
R16   AC<5>   LVCMOS25_S_12
AA7   MD<6>   LVCMOS25_S_12
G19   RD2out<6>   LVCMOS25_S_12
E10   eC   LVCMOS25_S_12
N17   AC<6>   LVCMOS25_S_12
R14   MD<7>   LVCMOS25_S_12
F19   RD2out<7>   LVCMOS25_S_12
R22   AC<7>   LVCMOS25_S_12
AA9   MD<8>   LVCMOS25_S_12
J18   RD2out<8>   LVCMOS25_S_12
Y22   mux2out<0>   LVCMOS25_S_12
V16   AC<8>   LVCMOS25_S_12
U15   MD<9>   LVCMOS25_S_12
J17   RD2out<9>   LVCMOS25_S_12
AA22   mux2out<1>   LVCMOS25_S_12
L21   AC<9>   LVCMOS25_S_12
AA21   mux2out<2>   LVCMOS25_S_12
Y21   mux2out<3>   LVCMOS25_S_12
AB20   mux2out<4>   LVCMOS25_S_12
V20   mux2out<10>   LVCMOS25_S_12
AB21   mux2out<5>   LVCMOS25_S_12
V21   mux2out<11>   LVCMOS25_S_12
T18   mux2out<6>   LVCMOS25_S_12
T19   mux2out<7>   LVCMOS25_S_12
Y20   mux2out<8>   LVCMOS25_S_12
W20   mux2out<9>   LVCMOS25_S_12
W7   RD1out<0>   LVCMOS25_S_12
L12   VP_0   NC
M11   VN_0   NC
D14   IO_L0P_25   NC
E14   IO_L0N_25   NC
B15   IO_L1P_25   NC
C15   IO_L1N_25   NC
A14   IO_L2P_25   NC
B14   IO_L2N_25   NC
D15   IO_L3P_25   NC
E15   IO_L3N_25   NC
F13   IO_L4P_25   NC
G13   IO_L4N_VREF_25   NC
A16   IO_L5P_25   NC
B16   IO_L5N_25   NC
F12   IO_L6P_25   NC
E12   IO_L6N_25   NC
A17   IO_L7P_25   NC
A18   IO_L7N_25   NC
C13   SRCC   LVCMOS25_F_12
D13   SRCC   LVCMOS25_F_12
E16   MRCC   LVCMOS25_F_12
F16   MRCC   LVCMOS25_F_12
A19   MRCC   LVCMOS25_F_12
B19   MRCC   LVCMOS25_F_12
C16   SRCC   LVCMOS25_F_12
C17   SRCC   LVCMOS25_F_12
A13   IO_L12P_25   NC
B13   IO_L12N_25   NC
B18   IO_L13P_25   NC
C18   IO_L13N_25   NC
G14   IO_L14P_25   NC
F14   IO_L14N_VREF_25   NC
G16   IO_L15P_25   NC
H16   IO_L15N_25   NC
H12   IO_L16P_VRN_25   NC
H13   IO_L16N_VRP_25   NC
D17   IO_L17P_25   NC
D18   IO_L17N_25   NC
G15   IO_L18P_GC_25   NC
H15   IO_L18N_GC_25   NC
E17   IO_L19P_GC_25   NC
F17   IO_L19N_GC_25   NC
A8   SM2P   LVCMOS25_F_12
B8   SM2N   LVCMOS25_F_12
A7   SM3P   LVCMOS25_F_12
A6   SM3N   LVCMOS25_F_12
C6   SM4P   LVCMOS25_F_12
B6   SM4N   LVCMOS25_F_12
G10   SRCC   LVCMOS25_F_12
H10   SRCC   LVCMOS25_F_12
E9   MRCC   LVCMOS25_F_12
D9   MRCC   LVCMOS25_F_12
C8   MRCC   LVCMOS25_F_12
C7   MRCC   LVCMOS25_F_12
D8   SRCC   LVCMOS25_F_12
D7   SRCC   LVCMOS25_F_12
F9   SM5P   LVCMOS25_F_12
G9   SM5N   LVCMOS25_F_12
E7   SM6P   LVCMOS25_F_12
E6   SM6N   LVCMOS25_F_12
E11   IO_L14P_35   NC
F11   IO_L14N_VREF_35   NC
F8   SM7P   LVCMOS25_F_12
F7   SM7N   LVCMOS25_F_12
G11   IO_L16P_VRN_35   NC
H11   IO_L16N_VRP_35   NC
G8   IO_L17P_35   NC
H8   IO_L17N_35   NC
D12   IO_L18P_GC_35   NC
C12   IO_L18N_GC_35   NC
F6   IO_L19P_GC_35   NC
G6   IO_L19N_GC_35   NC
M2   MGTTXN3_114   NC
W4   MGTRXN3_114   NC
M1   MGTTXP3_114   NC
W3   MGTRXP3_114   NC
P2   MGTTXN2_114   NC
Y2   MGTRXN2_114   NC
P1   MGTTXP2_114   NC
R4   MGTREFCLK1P_114   NC
R3   MGTREFCLK1N_114   NC
Y1   MGTRXP2_114   NC
U4   MGTREFCLK0P_114   NC
U3   MGTREFCLK0N_114   NC
T2   MGTTXN1_114   NC
AA4   MGTRXN1_114   NC
T1   MGTTXP1_114   NC
AA3   MGTRXP1_114   NC
V2   MGTTXN0_114   NC
AB2   MGTRXN0_114   NC
V1   MGTTXP0_114   NC
AB1   MGTRXP0_114   NC
D2   MGTTXN3_115   NC
B2   MGTRXN3_115   NC
D1   MGTTXP3_115   NC
B1   MGTRXP3_115   NC
F2   MGTTXN2_115   NC
C4   MGTRXN2_115   NC
F1   MGTTXP2_115   NC
J4   MGTREFCLK1P_115   NC
J3   MGTREFCLK1N_115   NC
C3   MGTRXP2_115   NC
L4   MGTREFCLK0P_115   NC
L3   MGTREFCLK0N_115   NC
H2   MGTTXN1_115   NC
E4   MGTRXN1_115   NC
H1   MGTTXP1_115   NC
E3   MGTRXP1_115   NC
K2   MGTTXN0_115   NC
G4   MGTRXN0_115   NC
K1   MGTTXP0_115   NC
G3   MGTRXP0_115   NC
H5   INIT_B_0   LVCMOS25_F_12
K6   DONE_0   LVCMOS25_F_12
J7   M1_0   LVCMOS25_F_12
H6   M2_0   LVCMOS25_F_12
L6   HSWAPEN_0   NC
F5   PROGRAM_B_0   LVCMOS25_F_12
H7   M0_0   LVCMOS25_F_12
K11   AVSS_0   NC
K12   AVDD_0   NC
M12   VREFP_0   NC
L11   VREFN_0   NC
N12   DXP_0   LVCMOS25_F_12
N11   DXN_0   LVCMOS25_F_12
T5   VBATT_0   NC
Y5   DIN_0   LVCMOS25_F_12
V5   RDWR_B_0   LVCMOS25_F_12
M7   CSI_B_0   LVCMOS25_F_12
N6   DOUT_BUSY_0   LVCMOS25_F_12
M6   CCLK_0   LVCMOS25_F_12
R7   TDO_0   LVCMOS25_F_12
R6   TCK_0   LVCMOS25_F_12
N7   TMS_0   LVCMOS25_F_12
P7   TDI_0   LVCMOS25_F_12
L7   VFS_0   NC
A4   MGTAVTTRCAL_115   NC
A3   MGTRREF_115   NC
J10   VCCINT   POWER
J12   VCCINT   POWER
J14   VCCINT   POWER
K9   VCCINT   POWER
K13   VCCINT   POWER
K15   VCCINT   POWER
L10   VCCINT   POWER
L14   VCCINT   POWER
M9   VCCINT   POWER
M13   VCCINT   POWER
M15   VCCINT   POWER
N10   VCCINT   POWER
N14   VCCINT   POWER
P9   VCCINT   POWER
P11   VCCINT   POWER
P13   VCCINT   POWER
R10   VCCINT   POWER
R12   VCCINT   POWER
J8   VCCAUX   POWER
J16   VCCAUX   POWER
L8   VCCAUX   POWER
L16   VCCAUX   POWER
N8   VCCAUX   POWER
N16   VCCAUX   POWER
P15   VCCAUX   POWER
R8   VCCAUX   POWER
A1   GND   GND
A15   GND   GND
A2   GND   GND
A22   GND   GND
A5   GND   GND
AA1   GND   GND
AA15   GND   GND
AA5   GND   GND
AB12   GND   GND
AB22   GND   GND
AB4   GND   GND
AB5   GND   GND
B12   GND   GND
B4   GND   GND
B5   GND   GND
C1   GND   GND
C19   GND   GND
C5   GND   GND
C9   GND   GND
D16   GND   GND
D3   GND   GND
D5   GND   GND
D6   GND   GND
E1   GND   GND
E13   GND   GND
E5   GND   GND
F10   GND   GND
F20   GND   GND
F3   GND   GND
G1   GND   GND
G17   GND   GND
G5   GND   GND
G7   GND   GND
H14   GND   GND
H3   GND   GND
J1   GND   GND
J11   GND   GND
J13   GND   GND
J15   GND   GND
J2   GND   GND
J21   GND   GND
J5   GND   GND
J6   GND   GND
J9   GND   GND
K10   GND   GND
K14   GND   GND
K16   GND   GND
K18   GND   GND
K3   GND   GND
K5   GND   GND
K8   GND   GND
L1   GND   GND
L13   GND   GND
L15   GND   GND
L2   GND   GND
L5   GND   GND
L9   GND   GND
M10   GND   GND
M14   GND   GND
M16   GND   GND
M22   GND   GND
M3   GND   GND
M5   GND   GND
M8   GND   GND
N1   GND   GND
N13   GND   GND
N15   GND   GND
N19   GND   GND
N4   GND   GND
N5   GND   GND
N9   GND   GND
P10   GND   GND
P12   GND   GND
P14   GND   GND
P16   GND   GND
P3   GND   GND
P5   GND   GND
P8   GND   GND
R1   GND   GND
R11   GND   GND
R13   GND   GND
R2   GND   GND
R5   GND   GND
T10   GND   GND
T20   GND   GND
T3   GND   GND
U1   GND   GND
U17   GND   GND
U2   GND   GND
U5   GND   GND
U7   GND   GND
V14   GND   GND
V3   GND   GND
W1   GND   GND
W11   GND   GND
W21   GND   GND
W5   GND   GND
Y18   GND   GND
Y4   GND   GND
Y8   GND   GND
K7   VCCO_0   POWER
P6   VCCO_0   POWER
AA20   VCCO_14   POWER
M17   VCCO_14   POWER
P21   VCCO_14   POWER
R18   VCCO_14   POWER
U22   VCCO_14   POWER
A20   VCCO_15   POWER
D21   VCCO_15   POWER
G22   VCCO_15   POWER
H19   VCCO_15   POWER
L20   VCCO_15   POWER
AB17   VCCO_24   POWER
T15   VCCO_24   POWER
V19   VCCO_24   POWER
W16   VCCO_24   POWER
Y13   VCCO_24   POWER
B17   VCCO_25   POWER
C14   VCCO_25   POWER
E18   VCCO_25   POWER
F15   VCCO_25   POWER
G12   VCCO_25   POWER
AA10   VCCO_34   POWER
AB7   VCCO_34   POWER
U12   VCCO_34   POWER
V9   VCCO_34   POWER
W6   VCCO_34   POWER
A10   VCCO_35   POWER
B7   VCCO_35   POWER
D11   VCCO_35   POWER
E8   VCCO_35   POWER
H9   VCCO_35   POWER
D4   MGTAVCC   NC
F4   MGTAVCC   NC
H4   MGTAVCC   NC
K4   MGTAVCC   NC
M4   MGTAVCC   NC
P4   MGTAVCC   NC
T4   MGTAVCC   NC
V4   MGTAVCC   NC
AA2   MGTAVTT   NC
AB3   MGTAVTT   NC
B3   MGTAVTT   NC
C2   MGTAVTT   NC
E2   MGTAVTT   NC
G2   MGTAVTT   NC
N2   MGTAVTT   NC
N3   MGTAVTT   NC
W2   MGTAVTT   NC
Y3   MGTAVTT   NC
[Package Model]   ff484_xc6vlx75t
[Diff Pin]   inv_pin   vdiff   tdelay_typ   tdelay_min   tdelay_max
[Series Pin Mapping] pin_2   model_name   function_table_group
[Define Package Model]  ff484_xc6vlx75t
[Manufacturer]   Xilinx Inc.
[OEM]   Xilinx_K1
[Description]   484 ball organic flip-chip
|[Number of Sections]   1
[Number of Pins]   319
[Pin Numbers]
|[Pin Name]  Net Number   Net Name   Net's All Pins
J16   | 1   VCCAUX   J16
   |J8
   |L16
   |L8
   |N16
   |N8
   |P15
   |R8
J10   | 2   VCCINT   J10
   |J12
   |J14
   |K13
   |K15
   |K9
   |L10
   |L14
   |M13
   |M15
   |M9
   |N10
   |N14
   |P11
   |P13
   |P9
   |R10
   |R12
K7   | 3   VCCO_0   K7
   |P6
AA20   | 4   VCCO_14   AA20
   |M17
   |P21
   |R18
   |U22
A20   | 5   VCCO_15   A20
   |D21
   |G22
   |H19
   |L20
AB17   | 6   VCCO_24   AB17
   |T15
   |V19
   |W16
   |Y13
B17   | 7   VCCO_25   B17
   |C14
   |E18
   |F15
   |G12
AA10   | 8   VCCO_34   AA10
   |AB7
   |U12
   |V9
   |W6
A10   | 9   VCCO_35   A10
   |B7
   |D11
   |E8
   |H9
K12   | 10   AVDD_0   K12
K11   | 11   AVSS_0   K11
M6   | 12   CCLK_0   M6
M7   | 13   CSI_B_0   M7
Y5   | 14   DIN_0   Y5
K6   | 15   DONE_0   K6
N6   | 16   DOUT_BUSY_0   N6
N11   | 17   DXN_0   N11
N12   | 18   DXP_0   N12
L6   | 19   HSWAPEN_0   L6
H5   | 20   INIT_B_0   H5
N18   | 21   IO_L0N_14   N18
C20   | 22   IO_L0N_15   C20
E14   | 23   IO_L0N_25   E14
A11   | 24   IO_L0N_35   A11
U13   | 25   IO_L0N_GC_24   U13
W12   | 26   IO_L0N_GC_34   W12
M18   | 27   IO_L0P_14   M18
B20   | 28   IO_L0P_15   B20
D14   | 29   IO_L0P_25   D14
A12   | 30   IO_L0P_35   A12
T13   | 31   IO_L0P_GC_24   T13
V12   | 32   IO_L0P_GC_34   V12
V22   | 33   IO_L10N_MRCC_14   V22
D22   | 34   IO_L10N_MRCC_15   D22
AA17   | 35   IO_L10N_MRCC_24   AA17
B19   | 36   IO_L10N_MRCC_25   B19
Y9   | 37   IO_L10N_MRCC_34   Y9
C7   | 38   IO_L10N_MRCC_35   C7
W22   | 39   IO_L10P_MRCC_14   W22
C22   | 40   IO_L10P_MRCC_15   C22
Y17   | 41   IO_L10P_MRCC_24   Y17
A19   | 42   IO_L10P_MRCC_25   A19
AA9   | 43   IO_L10P_MRCC_34   AA9
C8   | 44   IO_L10P_MRCC_35   C8
R20   | 45   IO_L11N_SRCC_14   R20
E22   | 46   IO_L11N_SRCC_15   E22
Y16   | 47   IO_L11N_SRCC_24   Y16
C17   | 48   IO_L11N_SRCC_25   C17
U9   | 49   IO_L11N_SRCC_34   U9
D7   | 50   IO_L11N_SRCC_35   D7
R19   | 51   IO_L11P_SRCC_14   R19
E21   | 52   IO_L11P_SRCC_15   E21
AA16   | 53   IO_L11P_SRCC_24   AA16
C16   | 54   IO_L11P_SRCC_25   C16
V10   | 55   IO_L11P_SRCC_34   V10
D8   | 56   IO_L11P_SRCC_35   D8
B13   | 57   IO_L12N_25   B13
W8   | 58   IO_L12N_A02_D18_34   W8
R15   | 59   IO_L12N_D2_FS2_24   R15
F22   | 60   IO_L12N_SM13N_15   F22
G9   | 61   IO_L12N_SM5N_35   G9
R17   | 62   IO_L12N_VRP_14   R17
A13   | 63   IO_L12P_25   A13
W9   | 64   IO_L12P_A03_D19_34   W9
R14   | 65   IO_L12P_D3_24   R14
F21   | 66   IO_L12P_SM13P_15   F21
F9   | 67   IO_L12P_SM5P_35   F9
P18   | 68   IO_L12P_VRN_14   P18
U20   | 69   IO_L13N_14   U20
C18   | 70   IO_L13N_25   C18
U10   | 71   IO_L13N_A00_D16_34   U10
V15   | 72   IO_L13N_D0_FS0_24   V15
K20   | 73   IO_L13N_SM14N_15   K20
E6   | 74   IO_L13N_SM6N_35   E6
U19   | 75   IO_L13P_14   U19
B18   | 76   IO_L13P_25   B18
T9   | 77   IO_L13P_A01_D17_34   T9
U15   | 78   IO_L13P_D1_FS1_24   U15
J20   | 79   IO_L13P_SM14P_15   J20
E7   | 80   IO_L13P_SM6P_35   E7
AA22   | 81   IO_L14N_VREF_14   AA22
H18   | 82   IO_L14N_VREF_15   H18
F14   | 83   IO_L14N_VREF_25   F14
F11   | 84   IO_L14N_VREF_35   F11
Y10   | 85   IO_L14N_VREF_A24_34   Y10
Y15   | 86   IO_L14N_VREF_FOE_B_MOSI_24   Y15
Y22   | 87   IO_L14P_14   Y22
H17   | 88   IO_L14P_15   H17
G14   | 89   IO_L14P_25   G14
E11   | 90   IO_L14P_35   E11
W10   | 91   IO_L14P_A25_34   W10
W15   | 92   IO_L14P_FCS_B_24   W15
Y21   | 93   IO_L15N_14   Y21
H16   | 94   IO_L15N_25   H16
AB8   | 95   IO_L15N_A22_34   AB8
U14   | 96   IO_L15N_RS1_24   U14
H21   | 97   IO_L15N_SM15N_15   H21
F7   | 98   IO_L15N_SM7N_35   F7
AA21   | 99   IO_L15P_14   AA21
G16   | 100   IO_L15P_25   G16
AB9   | 101   IO_L15P_A23_34   AB9
T14   | 102   IO_L15P_FWE_B_24   T14
G21   | 103   IO_L15P_SM15P_15   G21
F8   | 104   IO_L15P_SM7P_35   F8
AB21   | 105   IO_L16N_14   AB21
AA12   | 106   IO_L16N_A20_34   AA12
AA13   | 107   IO_L16N_CSO_B_24   AA13
L19   | 108   IO_L16N_VRP_15   L19
H13   | 109   IO_L16N_VRP_25   H13
H11   | 110   IO_L16N_VRP_35   H11
AB20   | 111   IO_L16P_14   AB20
Y12   | 112   IO_L16P_A21_34   Y12
AB13   | 113   IO_L16P_RS0_24   AB13
L18   | 114   IO_L16P_VRN_15   L18
H12   | 115   IO_L16P_VRN_25   H12
G11   | 116   IO_L16P_VRN_35   G11
T19   | 117   IO_L17N_14   T19
G20   | 118   IO_L17N_15   G20
D18   | 119   IO_L17N_25   D18
H8   | 120   IO_L17N_35   H8
V11   | 121   IO_L17N_A18_34   V11
W14   | 122   IO_L17N_VRP_24   W14
T18   | 123   IO_L17P_14   T18
H20   | 124   IO_L17P_15   H20
D17   | 125   IO_L17P_25   D17
G8   | 126   IO_L17P_35   G8
U11   | 127   IO_L17P_A19_34   U11
Y14   | 128   IO_L17P_VRN_24   Y14
W20   | 129   IO_L18N_14   W20
H22   | 130   IO_L18N_15   H22
AA14   | 131   IO_L18N_24   AA14
Y11   | 132   IO_L18N_A16_34   Y11
H15   | 133   IO_L18N_GC_25   H15
C12   | 134   IO_L18N_GC_35   C12
Y20   | 135   IO_L18P_14   Y20
J22   | 136   IO_L18P_15   J22
AB14   | 137   IO_L18P_24   AB14
AA11   | 138   IO_L18P_A17_34   AA11
G15   | 139   IO_L18P_GC_25   G15
D12   | 140   IO_L18P_GC_35   D12
V21   | 141   IO_L19N_14   V21
K22   | 142   IO_L19N_15   K22
AB16   | 143   IO_L19N_24   AB16
F17   | 144   IO_L19N_GC_25   F17
G6   | 145   IO_L19N_GC_35   G6
AB10   | 146   IO_L19N_VRP_34   AB10
V20   | 147   IO_L19P_14   V20
K21   | 148   IO_L19P_15   K21
AB15   | 149   IO_L19P_24   AB15
E17   | 150   IO_L19P_GC_25   E17
F6   | 151   IO_L19P_GC_35   F6
AB11   | 152   IO_L19P_VRN_34   AB11
M19   | 153   IO_L1N_14   M19
F18   | 154   IO_L1N_15   F18
C15   | 155   IO_L1N_25   C15
C10   | 156   IO_L1N_35   C10
U18   | 157   IO_L1N_GC_24   U18
T7   | 158   IO_L1N_GC_34   T7
M20   | 159   IO_L1P_14   M20
G18   | 160   IO_L1P_15   G18
B15   | 161   IO_L1P_25   B15
B10   | 162   IO_L1P_35   B10
T17   | 163   IO_L1P_GC_24   T17
T6   | 164   IO_L1P_GC_34   T6
N21   | 165   IO_L2N_14   N21
B14   | 166   IO_L2N_25   B14
T8   | 167   IO_L2N_A14_D30_34   T8
R16   | 168   IO_L2N_D14_24   R16
B11   | 169   IO_L2N_SM0N_35   B11
B21   | 170   IO_L2N_SM8N_15   B21
N22   | 171   IO_L2P_14   N22
A14   | 172   IO_L2P_25   A14
R9   | 173   IO_L2P_A15_D31_34   R9
T16   | 174   IO_L2P_D15_24   T16
C11   | 175   IO_L2P_SM0P_35   C11
A21   | 176   IO_L2P_SM8P_15   A21
L21   | 177   IO_L3N_14   L21
E15   | 178   IO_L3N_25   E15
V6   | 179   IO_L3N_A12_D28_34   V6
V18   | 180   IO_L3N_D12_24   V18
B9   | 181   IO_L3N_SM1N_35   B9
F19   | 182   IO_L3N_SM9N_15   F19
L22   | 183   IO_L3P_14   L22
D15   | 184   IO_L3P_25   D15
U6   | 185   IO_L3P_A13_D29_34   U6
V17   | 186   IO_L3P_D13_24   V17
A9   | 187   IO_L3P_SM1P_35   A9
G19   | 188   IO_L3P_SM9P_15   G19
R22   | 189   IO_L4N_VREF_14   R22
J17   | 190   IO_L4N_VREF_15   J17
G13   | 191   IO_L4N_VREF_25   G13
E10   | 192   IO_L4N_VREF_35   E10
T11   | 193   IO_L4N_VREF_A10_D26_34   T11
W13   | 194   IO_L4N_VREF_D10_24   W13
P22   | 195   IO_L4P_14   P22
J18   | 196   IO_L4P_15   J18
F13   | 197   IO_L4P_25   F13
D10   | 198   IO_L4P_35   D10
T12   | 199   IO_L4P_A11_D27_34   T12
V13   | 200   IO_L4P_D11_24   V13
T22   | 201   IO_L5N_14   T22
B16   | 202   IO_L5N_25   B16
W7   | 203   IO_L5N_A08_D24_34   W7
W17   | 204   IO_L5N_D8_24   W17
C21   | 205   IO_L5N_SM10N_15   C21
B8   | 206   IO_L5N_SM2N_35   B8
R21   | 207   IO_L5P_14   R21
A16   | 208   IO_L5P_25   A16
V7   | 209   IO_L5P_A09_D25_34   V7
W18   | 210   IO_L5P_D9_24   W18
B22   | 211   IO_L5P_SM10P_15   B22
A8   | 212   IO_L5P_SM2P_35   A8
P17   | 213   IO_L6N_14   P17
E12   | 214   IO_L6N_25   E12
U8   | 215   IO_L6N_A06_D22_34   U8
U16   | 216   IO_L6N_D6_24   U16
L17   | 217   IO_L6N_SM11N_15   L17
A6   | 218   IO_L6N_SM3N_35   A6
N17   | 219   IO_L6P_14   N17
F12   | 220   IO_L6P_25   F12
V8   | 221   IO_L6P_A07_D23_34   V8
V16   | 222   IO_L6P_D7_24   V16
K17   | 223   IO_L6P_SM11P_15   K17
A7   | 224   IO_L6P_SM3P_35   A7
N20   | 225   IO_L7N_14   N20
A18   | 226   IO_L7N_25   A18
Y7   | 227   IO_L7N_A04_D20_34   Y7
Y19   | 228   IO_L7N_D4_24   Y19
D19   | 229   IO_L7N_SM12N_15   D19
B6   | 230   IO_L7N_SM4N_35   B6
M21   | 231   IO_L7P_14   M21
A17   | 232   IO_L7P_25   A17
Y6   | 233   IO_L7P_A05_D21_34   Y6
W19   | 234   IO_L7P_D5_24   W19
E19   | 235   IO_L7P_SM12P_15   E19
C6   | 236   IO_L7P_SM4P_35   C6
T21   | 237   IO_L8N_SRCC_14   T21
J19   | 238   IO_L8N_SRCC_15   J19
AA18   | 239   IO_L8N_SRCC_24   AA18
D13   | 240   IO_L8N_SRCC_25   D13
AA6   | 241   IO_L8N_SRCC_34   AA6
H10   | 242   IO_L8N_SRCC_35   H10
U21   | 243   IO_L8P_SRCC_14   U21
K19   | 244   IO_L8P_SRCC_15   K19
AB18   | 245   IO_L8P_SRCC_24   AB18
C13   | 246   IO_L8P_SRCC_25   C13
AB6   | 247   IO_L8P_SRCC_34   AB6
G10   | 248   IO_L8P_SRCC_35   G10
P20   | 249   IO_L9N_MRCC_14   P20
E20   | 250   IO_L9N_MRCC_15   E20
AB19   | 251   IO_L9N_MRCC_24   AB19
F16   | 252   IO_L9N_MRCC_25   F16
AA8   | 253   IO_L9N_MRCC_34   AA8
D9   | 254   IO_L9N_MRCC_35   D9
P19   | 255   IO_L9P_MRCC_14   P19
D20   | 256   IO_L9P_MRCC_15   D20
AA19   | 257   IO_L9P_MRCC_24   AA19
E16   | 258   IO_L9P_MRCC_25   E16
AA7   | 259   IO_L9P_MRCC_34   AA7
E9   | 260   IO_L9P_MRCC_35   E9
H7   | 261   M0_0   H7
J7   | 262   M1_0   J7
H6   | 263   M2_0   H6
D4   | 264   MGTAVCC   D4
   |F4
   |H4
   |K4
   |M4
   |P4
   |T4
   |V4
AA2   | 265   MGTAVTT   AA2
   |AB3
   |B3
   |C2
   |E2
   |G2
   |N2
   |N3
   |W2
   |Y3
A4   | 266   MGTAVTTRCAL_115   A4
U3   | 267   MGTREFCLK0N_114   U3
L3   | 268   MGTREFCLK0N_115   L3
U4   | 269   MGTREFCLK0P_114   U4
L4   | 270   MGTREFCLK0P_115   L4
R3   | 271   MGTREFCLK1N_114   R3
J3   | 272   MGTREFCLK1N_115   J3
R4   | 273   MGTREFCLK1P_114   R4
J4   | 274   MGTREFCLK1P_115   J4
A3   | 275   MGTRREF_115   A3
AB2   | 276   MGTRXN0_114   AB2
G4   | 277   MGTRXN0_115   G4
AA4   | 278   MGTRXN1_114   AA4
E4   | 279   MGTRXN1_115   E4
Y2   | 280   MGTRXN2_114   Y2
C4   | 281   MGTRXN2_115   C4
W4   | 282   MGTRXN3_114   W4
B2   | 283   MGTRXN3_115   B2
AB1   | 284   MGTRXP0_114   AB1
G3   | 285   MGTRXP0_115   G3
AA3   | 286   MGTRXP1_114   AA3
E3   | 287   MGTRXP1_115   E3
Y1   | 288   MGTRXP2_114   Y1
C3   | 289   MGTRXP2_115   C3
W3   | 290   MGTRXP3_114   W3
B1   | 291   MGTRXP3_115   B1
V2   | 292   MGTTXN0_114   V2
K2   | 293   MGTTXN0_115   K2
T2   | 294   MGTTXN1_114   T2
H2   | 295   MGTTXN1_115   H2
P2   | 296   MGTTXN2_114   P2
F2   | 297   MGTTXN2_115   F2
M2   | 298   MGTTXN3_114   M2
D2   | 299   MGTTXN3_115   D2
V1   | 300   MGTTXP0_114   V1
K1   | 301   MGTTXP0_115   K1
T1   | 302   MGTTXP1_114   T1
H1   | 303   MGTTXP1_115   H1
P1   | 304   MGTTXP2_114   P1
F1   | 305   MGTTXP2_115   F1
M1   | 306   MGTTXP3_114   M1
D1   | 307   MGTTXP3_115   D1
F5   | 308   PROGRAM_B_0   F5
V5   | 309   RDWR_B_0   V5
R6   | 310   TCK_0   R6
P7   | 311   TDI_0   P7
R7   | 312   TDO_0   R7
N7   | 313   TMS_0   N7
T5   | 314   VBATT_0   T5
L7   | 315   VFS_0   L7
M11   | 316   VN_0   M11
L12   | 317   VP_0   L12
L11   | 318   VREFN_0   L11
M12   | 319   VREFP_0   M12
[Model Data]
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[End Model Data]
[End Package Model]
| Models and submodels in the file (2): LVCMOS25_F_12 (I/O), LVCMOS25_S_12 (I/O)
